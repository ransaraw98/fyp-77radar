# Ansys Electronics Desktop project, version 2018.0
project variables:
  $mid = (31/2) mm
materials:
  vacuum: permittivity=1
  Rogers RT/duroid 5880 (tm): permittivity=2.2 dielectric_loss_tangent=0.0009

design antenna (HFSS, DrivenModal, model units mm)
options: open_region{BoundaryType=0 OpFreq=78.5GHz}
variables:
  Wf = 0.07mm
  mid = (31/2) mm
  thickness = 0.127mm
  d1 = 2.35mm
  Ll1 = 1.1mm
  Wl1 = 0.3mm
  d2 = 2.4mm
  Ll2 = 0.9mm
  Wl2 = 0.58mm
  d3 = 2.65mm
  Ll3 = 1.5mm
  Wl3 = 1.1mm
geometry:
  Substrate [Rogers RT/duroid 5880 (tm)] = box(corner=(0mm, 0mm, 0mm), size=(21mm, 31mm, 0.127mm))
  ground = rectangle(corner=(0mm, 0mm, 0mm), x_size=21mm, y_size=31mm)
  EdgeFeedLine = rectangle(corner=(0mm, (31/2-0.035) mm, thickness), x_size=d1-Ll1/2, y_size=0.07mm)
  patch1 = rectangle(corner=(d1-Ll1/2, (31/2-0.15) mm, thickness), x_size=Ll1, y_size=Wl1)
  FeedLine2 = rectangle(corner=(d1+Ll1/2, 31/2-(0.035) mm, thickness), x_size=d2-(Ll1/2)-(Ll2/2), y_size=0.07mm)
  patch2 = rectangle(corner=(d1+d2-Ll2/2, (31/2-0.29) mm, thickness), x_size=Ll2, y_size=Wl2)
  FeedLine3 = rectangle(corner=(d1+d2+Ll2/2, (31/2-0.035) mm, thickness), x_size=d3-Ll3/2-Ll2/2, y_size=Wf)
  patch3 = rectangle(corner=(d1+d2+d3-Ll3/2, (15.5-0.55) mm, thickness), x_size=Ll3, y_size=Wl3)
  FeedLine4 = rectangle(corner=(d1+d2+d3+Ll3/2, (mid-Wf/2), 0.127mm), x_size=d3-Ll3, y_size=Wf)
  patch4 = rectangle(corner=(d1+d2+d3*2-Ll3/2, (15.5-0.55) mm, thickness), x_size=Ll3, y_size=Wl3)
  FeedLine5 = rectangle(corner=(d1+d2+d3*2+Ll3/2, (31/2-0.035) mm, thickness), x_size=d3-(Ll2/2)-Ll3/2, y_size=Wf)
  patch5 = rectangle(corner=(d1+d2+d3*3-Ll2/2, (31/2-0.29) mm, thickness), x_size=Ll2, y_size=Wl2)
  patch6 = rectangle(corner=(d1+d2*2+d3*3-Ll1/2, (31/2-0.15) mm, thickness), x_size=Ll1, y_size=Wl1)
  FeedLine6 = rectangle(corner=(d1+d2+d3*3+Ll2/2, 31/2-(0.035) mm, thickness), x_size=d2-(Ll1/2)-(Ll2/2), y_size=0.07mm)
  EdgeFeedLine.unite(FeedLine2..FeedLine6, patch1..patch6)
  port = rectangle(corner=(0mm, (31/2-0.035) mm, 0mm), y_size=0.07mm, z_size=0.127mm)
  RadiatingSurface [vacuum] = region(absolute_offset=1.2738854mm on all sides)
boundaries and excitations:
  PerfE1: Perfect E Objects=ground
  PerfE2: Perfect E Objects=EdgeFeedLine
  AutoOpen1: Radiation Objects=RadiatingSurface
  1: Lumped Port Objects=port Modes{Mode1{IntLine{middle of port.edge(z at corner) -> middle of port.edge(z opposite corner)} CharImp=Zpi RenormImp=50ohm}} Impedance=50ohm
setups:
  Auto1: HfssDriven AdaptMultipleFreqs MultipleAdaptiveFreqsSetup{Broadband{Low=77GHz High=80GHz}} MaxDeltaS=0.02 MaximumPasses=20 MinimumPasses=1 MinimumConvergedPasses=1 PercentRefinement=30 BasisOrder=1 PortAccuracy=2
    sweep Sweep: 77GHz to 80GHz, 451 points; Type=Interpolating InterpTolerance=0.5 InterpMaxSolns=250 InterpUsePortImped=false PassivityErrorTolerance=0.0001
    sweep Sweep1: 50GHz to 100GHz, 451 points; 77GHz to 80GHz, 451 points; Type=Interpolating InterpTolerance=0.5 InterpMaxSolns=250 InterpUsePortImped=false PassivityErrorTolerance=0.0001
source amplitudes:
  1:1: 1W 0deg
radiation setups:
  3D: Infinite Sphere Theta=0deg..180deg step 2deg Phi=-180deg..180deg step 2deg
  Elevation: Infinite Sphere Theta=-180deg..180deg step 1deg Phi=0deg..90deg step 90deg
  Azimuth: Infinite Sphere Theta=90deg..90deg step 0deg Phi=-180deg..180deg step 1deg
reports:
  S Parameter Plot 1: dB(S(1,1)) vs Freq on Auto1 : Sweep
  S Parameter Plot 2: dB(S(1,1)) vs Freq on Auto1 : Sweep1
